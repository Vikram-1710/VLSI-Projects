** Generated for: hspiceD
** Generated on: Feb  2 22:04:23 2026
** Design library name: Sem2_Project_1
** Design cell name: inv
** Design view name: schematic

** Library name: Sem2_Project_1
** Cell name: inv
** View name: schematic
xmdut7 i__ i gnd gnd nch_svt_mac l=16e-9 nfin=4 w=154e-9 multi=1 nf=1 sa=90e-9 sb=90e-9
xmdut3 i__ i vdd vdd pch_svt_mac l=16e-9 nfin=4 w=154e-9 multi=1 nf=1 sa=90e-9 sb=90e-9
.END
