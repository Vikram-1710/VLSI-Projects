** Sweep testbench: theta=15, x=0..32 (time-based sweep)
.TEMP 25
.OPTION POST
.lib /soft/ece_soft_2/TSMCHOME/Executable_Package/Collaterals/Tech/SPICE/N16ADFP_SPICE_MODEL/n16adfp_spice_model_v1d0_usage.l TTMacro_MOS_MOSCAP
.INCLUDE "/home/ragha084/tsmcN16_ragha084/Project_3/tlrelu_verification/tlrelu_topdff.sp"

.param TPER = 84p
.param N_CYC = 1

* Power supply
VDD vdd! 0 0.8

* Clock source
VCLK clk 0 PULSE(0 0.8 20p 20p 20p 'TPER/2' 'TPER')

* Theta = 15 constant
VT0 t<0> 0 0.8
VT1 t<1> 0 0.8
VT2 t<2> 0 0.8
VT3 t<3> 0 0.8

* X driven by PWL - sweeps from 0 to 32 over time
* Inputs change in middle of clock cycle with 20ps transitions
VX0 x<0> 0 PWL(
+ 0n 0
+ 0.210000n 0
+ 0.230000n 0.8
+ 0.378000n 0.8
+ 0.398000n 0
+ 0.546000n 0
+ 0.566000n 0.8
+ 0.714000n 0.8
+ 0.734000n 0
+ 0.882000n 0
+ 0.902000n 0.8
+ 1.050000n 0.8
+ 1.070000n 0
+ 1.218000n 0
+ 1.238000n 0.8
+ 1.386000n 0.8
+ 1.406000n 0
+ 1.554000n 0
+ 1.574000n 0.8
+ 1.722000n 0.8
+ 1.742000n 0
+ 1.890000n 0
+ 1.910000n 0.8
+ 2.058000n 0.8
+ 2.078000n 0
+ 2.226000n 0
+ 2.246000n 0.8
+ 2.394000n 0.8
+ 2.414000n 0
+ 2.562000n 0
+ 2.582000n 0.8
+ 2.730000n 0.8
+ 2.750000n 0
+ 2.898000n 0
+ 2.918000n 0.8
+ 3.066000n 0.8
+ 3.086000n 0
+ 3.234000n 0
+ 3.254000n 0.8
+ 3.402000n 0.8
+ 3.422000n 0
+ 3.570000n 0
+ 3.590000n 0.8
+ 3.738000n 0.8
+ 3.758000n 0
+ 3.906000n 0
+ 3.926000n 0.8
+ 4.074000n 0.8
+ 4.094000n 0
+ 4.242000n 0
+ 4.262000n 0.8
+ 4.410000n 0.8
+ 4.430000n 0
+ 4.578000n 0
+ 4.598000n 0.8
+ 4.746000n 0.8
+ 4.766000n 0
+ 4.914000n 0
+ 4.934000n 0.8
+ 5.082000n 0.8
+ 5.102000n 0
+ 5.250000n 0
+ 5.270000n 0.8
+ 5.418000n 0.8
+ 5.438000n 0
+ 5.586000n 0)

VX1 x<1> 0 PWL(
+ 0n 0
+ 0.378000n 0
+ 0.398000n 0.8
+ 0.714000n 0.8
+ 0.734000n 0
+ 1.050000n 0
+ 1.070000n 0.8
+ 1.386000n 0.8
+ 1.406000n 0
+ 1.722000n 0
+ 1.742000n 0.8
+ 2.058000n 0.8
+ 2.078000n 0
+ 2.394000n 0
+ 2.414000n 0.8
+ 2.730000n 0.8
+ 2.750000n 0
+ 3.066000n 0
+ 3.086000n 0.8
+ 3.402000n 0.8
+ 3.422000n 0
+ 3.738000n 0
+ 3.758000n 0.8
+ 4.074000n 0.8
+ 4.094000n 0
+ 4.410000n 0
+ 4.430000n 0.8
+ 4.746000n 0.8
+ 4.766000n 0
+ 5.082000n 0
+ 5.102000n 0.8
+ 5.418000n 0.8
+ 5.438000n 0
+ 5.586000n 0)

VX2 x<2> 0 PWL(
+ 0n 0
+ 0.714000n 0
+ 0.734000n 0.8
+ 1.386000n 0.8
+ 1.406000n 0
+ 2.058000n 0
+ 2.078000n 0.8
+ 2.730000n 0.8
+ 2.750000n 0
+ 3.402000n 0
+ 3.422000n 0.8
+ 4.074000n 0.8
+ 4.094000n 0
+ 4.746000n 0
+ 4.766000n 0.8
+ 5.418000n 0.8
+ 5.438000n 0
+ 5.586000n 0)

VX3 x<3> 0 PWL(
+ 0n 0
+ 1.386000n 0
+ 1.406000n 0.8
+ 2.730000n 0.8
+ 2.750000n 0
+ 4.074000n 0
+ 4.094000n 0.8
+ 5.418000n 0.8
+ 5.438000n 0
+ 5.586000n 0)

VX4 x<4> 0 PWL(
+ 0n 0
+ 2.730000n 0
+ 2.750000n 0.8
+ 5.418000n 0.8
+ 5.438000n 0
+ 5.586000n 0)

VX5 x<5> 0 PWL(
+ 0n 0
+ 5.418000n 0
+ 5.438000n 0.8
+ 5.586000n 0.8)

VX6 x<6> 0 PWL(
+ 0n 0
+ 5.586000n 0)

VX7 x<7> 0 PWL(
+ 0n 0
+ 5.586000n 0)

* DUT instance
XU0 clk d0 d1 d2 d3 gnd t<0> t<1> t<2> t<3> vdd! x<0> x<1> x<2> x<3> x<4> x<5> x<6> x<7> out<0> out<1> out<2> out<3> out<4> out<5> out<6> out<7> out<8> out<9> out<10> tlrelu_topdff

* Transient analysis
.TRAN 0.001680n 5.712000n

* Measurements after (N_CYC+1) clock cycles from input change
* Input changes at TPER/2, measure at TPER/2 + (N_CYC+1)*TPER
.MEASURE TRAN m_out0_x0 FIND V(out<0>) AT=0.210000n
.MEASURE TRAN m_out1_x0 FIND V(out<1>) AT=0.210000n
.MEASURE TRAN m_out2_x0 FIND V(out<2>) AT=0.210000n
.MEASURE TRAN m_out3_x0 FIND V(out<3>) AT=0.210000n
.MEASURE TRAN m_out4_x0 FIND V(out<4>) AT=0.210000n
.MEASURE TRAN m_out5_x0 FIND V(out<5>) AT=0.210000n
.MEASURE TRAN m_out6_x0 FIND V(out<6>) AT=0.210000n
.MEASURE TRAN m_out7_x0 FIND V(out<7>) AT=0.210000n
.MEASURE TRAN m_out8_x0 FIND V(out<8>) AT=0.210000n
.MEASURE TRAN m_out9_x0 FIND V(out<9>) AT=0.210000n
.MEASURE TRAN m_out10_x0 FIND V(out<10>) AT=0.210000n
.MEASURE TRAN m_out0_x1 FIND V(out<0>) AT=0.378000n
.MEASURE TRAN m_out1_x1 FIND V(out<1>) AT=0.378000n
.MEASURE TRAN m_out2_x1 FIND V(out<2>) AT=0.378000n
.MEASURE TRAN m_out3_x1 FIND V(out<3>) AT=0.378000n
.MEASURE TRAN m_out4_x1 FIND V(out<4>) AT=0.378000n
.MEASURE TRAN m_out5_x1 FIND V(out<5>) AT=0.378000n
.MEASURE TRAN m_out6_x1 FIND V(out<6>) AT=0.378000n
.MEASURE TRAN m_out7_x1 FIND V(out<7>) AT=0.378000n
.MEASURE TRAN m_out8_x1 FIND V(out<8>) AT=0.378000n
.MEASURE TRAN m_out9_x1 FIND V(out<9>) AT=0.378000n
.MEASURE TRAN m_out10_x1 FIND V(out<10>) AT=0.378000n
.MEASURE TRAN m_out0_x2 FIND V(out<0>) AT=0.546000n
.MEASURE TRAN m_out1_x2 FIND V(out<1>) AT=0.546000n
.MEASURE TRAN m_out2_x2 FIND V(out<2>) AT=0.546000n
.MEASURE TRAN m_out3_x2 FIND V(out<3>) AT=0.546000n
.MEASURE TRAN m_out4_x2 FIND V(out<4>) AT=0.546000n
.MEASURE TRAN m_out5_x2 FIND V(out<5>) AT=0.546000n
.MEASURE TRAN m_out6_x2 FIND V(out<6>) AT=0.546000n
.MEASURE TRAN m_out7_x2 FIND V(out<7>) AT=0.546000n
.MEASURE TRAN m_out8_x2 FIND V(out<8>) AT=0.546000n
.MEASURE TRAN m_out9_x2 FIND V(out<9>) AT=0.546000n
.MEASURE TRAN m_out10_x2 FIND V(out<10>) AT=0.546000n
.MEASURE TRAN m_out0_x3 FIND V(out<0>) AT=0.714000n
.MEASURE TRAN m_out1_x3 FIND V(out<1>) AT=0.714000n
.MEASURE TRAN m_out2_x3 FIND V(out<2>) AT=0.714000n
.MEASURE TRAN m_out3_x3 FIND V(out<3>) AT=0.714000n
.MEASURE TRAN m_out4_x3 FIND V(out<4>) AT=0.714000n
.MEASURE TRAN m_out5_x3 FIND V(out<5>) AT=0.714000n
.MEASURE TRAN m_out6_x3 FIND V(out<6>) AT=0.714000n
.MEASURE TRAN m_out7_x3 FIND V(out<7>) AT=0.714000n
.MEASURE TRAN m_out8_x3 FIND V(out<8>) AT=0.714000n
.MEASURE TRAN m_out9_x3 FIND V(out<9>) AT=0.714000n
.MEASURE TRAN m_out10_x3 FIND V(out<10>) AT=0.714000n
.MEASURE TRAN m_out0_x4 FIND V(out<0>) AT=0.882000n
.MEASURE TRAN m_out1_x4 FIND V(out<1>) AT=0.882000n
.MEASURE TRAN m_out2_x4 FIND V(out<2>) AT=0.882000n
.MEASURE TRAN m_out3_x4 FIND V(out<3>) AT=0.882000n
.MEASURE TRAN m_out4_x4 FIND V(out<4>) AT=0.882000n
.MEASURE TRAN m_out5_x4 FIND V(out<5>) AT=0.882000n
.MEASURE TRAN m_out6_x4 FIND V(out<6>) AT=0.882000n
.MEASURE TRAN m_out7_x4 FIND V(out<7>) AT=0.882000n
.MEASURE TRAN m_out8_x4 FIND V(out<8>) AT=0.882000n
.MEASURE TRAN m_out9_x4 FIND V(out<9>) AT=0.882000n
.MEASURE TRAN m_out10_x4 FIND V(out<10>) AT=0.882000n
.MEASURE TRAN m_out0_x5 FIND V(out<0>) AT=1.050000n
.MEASURE TRAN m_out1_x5 FIND V(out<1>) AT=1.050000n
.MEASURE TRAN m_out2_x5 FIND V(out<2>) AT=1.050000n
.MEASURE TRAN m_out3_x5 FIND V(out<3>) AT=1.050000n
.MEASURE TRAN m_out4_x5 FIND V(out<4>) AT=1.050000n
.MEASURE TRAN m_out5_x5 FIND V(out<5>) AT=1.050000n
.MEASURE TRAN m_out6_x5 FIND V(out<6>) AT=1.050000n
.MEASURE TRAN m_out7_x5 FIND V(out<7>) AT=1.050000n
.MEASURE TRAN m_out8_x5 FIND V(out<8>) AT=1.050000n
.MEASURE TRAN m_out9_x5 FIND V(out<9>) AT=1.050000n
.MEASURE TRAN m_out10_x5 FIND V(out<10>) AT=1.050000n
.MEASURE TRAN m_out0_x6 FIND V(out<0>) AT=1.218000n
.MEASURE TRAN m_out1_x6 FIND V(out<1>) AT=1.218000n
.MEASURE TRAN m_out2_x6 FIND V(out<2>) AT=1.218000n
.MEASURE TRAN m_out3_x6 FIND V(out<3>) AT=1.218000n
.MEASURE TRAN m_out4_x6 FIND V(out<4>) AT=1.218000n
.MEASURE TRAN m_out5_x6 FIND V(out<5>) AT=1.218000n
.MEASURE TRAN m_out6_x6 FIND V(out<6>) AT=1.218000n
.MEASURE TRAN m_out7_x6 FIND V(out<7>) AT=1.218000n
.MEASURE TRAN m_out8_x6 FIND V(out<8>) AT=1.218000n
.MEASURE TRAN m_out9_x6 FIND V(out<9>) AT=1.218000n
.MEASURE TRAN m_out10_x6 FIND V(out<10>) AT=1.218000n
.MEASURE TRAN m_out0_x7 FIND V(out<0>) AT=1.386000n
.MEASURE TRAN m_out1_x7 FIND V(out<1>) AT=1.386000n
.MEASURE TRAN m_out2_x7 FIND V(out<2>) AT=1.386000n
.MEASURE TRAN m_out3_x7 FIND V(out<3>) AT=1.386000n
.MEASURE TRAN m_out4_x7 FIND V(out<4>) AT=1.386000n
.MEASURE TRAN m_out5_x7 FIND V(out<5>) AT=1.386000n
.MEASURE TRAN m_out6_x7 FIND V(out<6>) AT=1.386000n
.MEASURE TRAN m_out7_x7 FIND V(out<7>) AT=1.386000n
.MEASURE TRAN m_out8_x7 FIND V(out<8>) AT=1.386000n
.MEASURE TRAN m_out9_x7 FIND V(out<9>) AT=1.386000n
.MEASURE TRAN m_out10_x7 FIND V(out<10>) AT=1.386000n
.MEASURE TRAN m_out0_x8 FIND V(out<0>) AT=1.554000n
.MEASURE TRAN m_out1_x8 FIND V(out<1>) AT=1.554000n
.MEASURE TRAN m_out2_x8 FIND V(out<2>) AT=1.554000n
.MEASURE TRAN m_out3_x8 FIND V(out<3>) AT=1.554000n
.MEASURE TRAN m_out4_x8 FIND V(out<4>) AT=1.554000n
.MEASURE TRAN m_out5_x8 FIND V(out<5>) AT=1.554000n
.MEASURE TRAN m_out6_x8 FIND V(out<6>) AT=1.554000n
.MEASURE TRAN m_out7_x8 FIND V(out<7>) AT=1.554000n
.MEASURE TRAN m_out8_x8 FIND V(out<8>) AT=1.554000n
.MEASURE TRAN m_out9_x8 FIND V(out<9>) AT=1.554000n
.MEASURE TRAN m_out10_x8 FIND V(out<10>) AT=1.554000n
.MEASURE TRAN m_out0_x9 FIND V(out<0>) AT=1.722000n
.MEASURE TRAN m_out1_x9 FIND V(out<1>) AT=1.722000n
.MEASURE TRAN m_out2_x9 FIND V(out<2>) AT=1.722000n
.MEASURE TRAN m_out3_x9 FIND V(out<3>) AT=1.722000n
.MEASURE TRAN m_out4_x9 FIND V(out<4>) AT=1.722000n
.MEASURE TRAN m_out5_x9 FIND V(out<5>) AT=1.722000n
.MEASURE TRAN m_out6_x9 FIND V(out<6>) AT=1.722000n
.MEASURE TRAN m_out7_x9 FIND V(out<7>) AT=1.722000n
.MEASURE TRAN m_out8_x9 FIND V(out<8>) AT=1.722000n
.MEASURE TRAN m_out9_x9 FIND V(out<9>) AT=1.722000n
.MEASURE TRAN m_out10_x9 FIND V(out<10>) AT=1.722000n
.MEASURE TRAN m_out0_x10 FIND V(out<0>) AT=1.890000n
.MEASURE TRAN m_out1_x10 FIND V(out<1>) AT=1.890000n
.MEASURE TRAN m_out2_x10 FIND V(out<2>) AT=1.890000n
.MEASURE TRAN m_out3_x10 FIND V(out<3>) AT=1.890000n
.MEASURE TRAN m_out4_x10 FIND V(out<4>) AT=1.890000n
.MEASURE TRAN m_out5_x10 FIND V(out<5>) AT=1.890000n
.MEASURE TRAN m_out6_x10 FIND V(out<6>) AT=1.890000n
.MEASURE TRAN m_out7_x10 FIND V(out<7>) AT=1.890000n
.MEASURE TRAN m_out8_x10 FIND V(out<8>) AT=1.890000n
.MEASURE TRAN m_out9_x10 FIND V(out<9>) AT=1.890000n
.MEASURE TRAN m_out10_x10 FIND V(out<10>) AT=1.890000n
.MEASURE TRAN m_out0_x11 FIND V(out<0>) AT=2.058000n
.MEASURE TRAN m_out1_x11 FIND V(out<1>) AT=2.058000n
.MEASURE TRAN m_out2_x11 FIND V(out<2>) AT=2.058000n
.MEASURE TRAN m_out3_x11 FIND V(out<3>) AT=2.058000n
.MEASURE TRAN m_out4_x11 FIND V(out<4>) AT=2.058000n
.MEASURE TRAN m_out5_x11 FIND V(out<5>) AT=2.058000n
.MEASURE TRAN m_out6_x11 FIND V(out<6>) AT=2.058000n
.MEASURE TRAN m_out7_x11 FIND V(out<7>) AT=2.058000n
.MEASURE TRAN m_out8_x11 FIND V(out<8>) AT=2.058000n
.MEASURE TRAN m_out9_x11 FIND V(out<9>) AT=2.058000n
.MEASURE TRAN m_out10_x11 FIND V(out<10>) AT=2.058000n
.MEASURE TRAN m_out0_x12 FIND V(out<0>) AT=2.226000n
.MEASURE TRAN m_out1_x12 FIND V(out<1>) AT=2.226000n
.MEASURE TRAN m_out2_x12 FIND V(out<2>) AT=2.226000n
.MEASURE TRAN m_out3_x12 FIND V(out<3>) AT=2.226000n
.MEASURE TRAN m_out4_x12 FIND V(out<4>) AT=2.226000n
.MEASURE TRAN m_out5_x12 FIND V(out<5>) AT=2.226000n
.MEASURE TRAN m_out6_x12 FIND V(out<6>) AT=2.226000n
.MEASURE TRAN m_out7_x12 FIND V(out<7>) AT=2.226000n
.MEASURE TRAN m_out8_x12 FIND V(out<8>) AT=2.226000n
.MEASURE TRAN m_out9_x12 FIND V(out<9>) AT=2.226000n
.MEASURE TRAN m_out10_x12 FIND V(out<10>) AT=2.226000n
.MEASURE TRAN m_out0_x13 FIND V(out<0>) AT=2.394000n
.MEASURE TRAN m_out1_x13 FIND V(out<1>) AT=2.394000n
.MEASURE TRAN m_out2_x13 FIND V(out<2>) AT=2.394000n
.MEASURE TRAN m_out3_x13 FIND V(out<3>) AT=2.394000n
.MEASURE TRAN m_out4_x13 FIND V(out<4>) AT=2.394000n
.MEASURE TRAN m_out5_x13 FIND V(out<5>) AT=2.394000n
.MEASURE TRAN m_out6_x13 FIND V(out<6>) AT=2.394000n
.MEASURE TRAN m_out7_x13 FIND V(out<7>) AT=2.394000n
.MEASURE TRAN m_out8_x13 FIND V(out<8>) AT=2.394000n
.MEASURE TRAN m_out9_x13 FIND V(out<9>) AT=2.394000n
.MEASURE TRAN m_out10_x13 FIND V(out<10>) AT=2.394000n
.MEASURE TRAN m_out0_x14 FIND V(out<0>) AT=2.562000n
.MEASURE TRAN m_out1_x14 FIND V(out<1>) AT=2.562000n
.MEASURE TRAN m_out2_x14 FIND V(out<2>) AT=2.562000n
.MEASURE TRAN m_out3_x14 FIND V(out<3>) AT=2.562000n
.MEASURE TRAN m_out4_x14 FIND V(out<4>) AT=2.562000n
.MEASURE TRAN m_out5_x14 FIND V(out<5>) AT=2.562000n
.MEASURE TRAN m_out6_x14 FIND V(out<6>) AT=2.562000n
.MEASURE TRAN m_out7_x14 FIND V(out<7>) AT=2.562000n
.MEASURE TRAN m_out8_x14 FIND V(out<8>) AT=2.562000n
.MEASURE TRAN m_out9_x14 FIND V(out<9>) AT=2.562000n
.MEASURE TRAN m_out10_x14 FIND V(out<10>) AT=2.562000n
.MEASURE TRAN m_out0_x15 FIND V(out<0>) AT=2.730000n
.MEASURE TRAN m_out1_x15 FIND V(out<1>) AT=2.730000n
.MEASURE TRAN m_out2_x15 FIND V(out<2>) AT=2.730000n
.MEASURE TRAN m_out3_x15 FIND V(out<3>) AT=2.730000n
.MEASURE TRAN m_out4_x15 FIND V(out<4>) AT=2.730000n
.MEASURE TRAN m_out5_x15 FIND V(out<5>) AT=2.730000n
.MEASURE TRAN m_out6_x15 FIND V(out<6>) AT=2.730000n
.MEASURE TRAN m_out7_x15 FIND V(out<7>) AT=2.730000n
.MEASURE TRAN m_out8_x15 FIND V(out<8>) AT=2.730000n
.MEASURE TRAN m_out9_x15 FIND V(out<9>) AT=2.730000n
.MEASURE TRAN m_out10_x15 FIND V(out<10>) AT=2.730000n
.MEASURE TRAN m_out0_x16 FIND V(out<0>) AT=2.898000n
.MEASURE TRAN m_out1_x16 FIND V(out<1>) AT=2.898000n
.MEASURE TRAN m_out2_x16 FIND V(out<2>) AT=2.898000n
.MEASURE TRAN m_out3_x16 FIND V(out<3>) AT=2.898000n
.MEASURE TRAN m_out4_x16 FIND V(out<4>) AT=2.898000n
.MEASURE TRAN m_out5_x16 FIND V(out<5>) AT=2.898000n
.MEASURE TRAN m_out6_x16 FIND V(out<6>) AT=2.898000n
.MEASURE TRAN m_out7_x16 FIND V(out<7>) AT=2.898000n
.MEASURE TRAN m_out8_x16 FIND V(out<8>) AT=2.898000n
.MEASURE TRAN m_out9_x16 FIND V(out<9>) AT=2.898000n
.MEASURE TRAN m_out10_x16 FIND V(out<10>) AT=2.898000n
.MEASURE TRAN m_out0_x17 FIND V(out<0>) AT=3.066000n
.MEASURE TRAN m_out1_x17 FIND V(out<1>) AT=3.066000n
.MEASURE TRAN m_out2_x17 FIND V(out<2>) AT=3.066000n
.MEASURE TRAN m_out3_x17 FIND V(out<3>) AT=3.066000n
.MEASURE TRAN m_out4_x17 FIND V(out<4>) AT=3.066000n
.MEASURE TRAN m_out5_x17 FIND V(out<5>) AT=3.066000n
.MEASURE TRAN m_out6_x17 FIND V(out<6>) AT=3.066000n
.MEASURE TRAN m_out7_x17 FIND V(out<7>) AT=3.066000n
.MEASURE TRAN m_out8_x17 FIND V(out<8>) AT=3.066000n
.MEASURE TRAN m_out9_x17 FIND V(out<9>) AT=3.066000n
.MEASURE TRAN m_out10_x17 FIND V(out<10>) AT=3.066000n
.MEASURE TRAN m_out0_x18 FIND V(out<0>) AT=3.234000n
.MEASURE TRAN m_out1_x18 FIND V(out<1>) AT=3.234000n
.MEASURE TRAN m_out2_x18 FIND V(out<2>) AT=3.234000n
.MEASURE TRAN m_out3_x18 FIND V(out<3>) AT=3.234000n
.MEASURE TRAN m_out4_x18 FIND V(out<4>) AT=3.234000n
.MEASURE TRAN m_out5_x18 FIND V(out<5>) AT=3.234000n
.MEASURE TRAN m_out6_x18 FIND V(out<6>) AT=3.234000n
.MEASURE TRAN m_out7_x18 FIND V(out<7>) AT=3.234000n
.MEASURE TRAN m_out8_x18 FIND V(out<8>) AT=3.234000n
.MEASURE TRAN m_out9_x18 FIND V(out<9>) AT=3.234000n
.MEASURE TRAN m_out10_x18 FIND V(out<10>) AT=3.234000n
.MEASURE TRAN m_out0_x19 FIND V(out<0>) AT=3.402000n
.MEASURE TRAN m_out1_x19 FIND V(out<1>) AT=3.402000n
.MEASURE TRAN m_out2_x19 FIND V(out<2>) AT=3.402000n
.MEASURE TRAN m_out3_x19 FIND V(out<3>) AT=3.402000n
.MEASURE TRAN m_out4_x19 FIND V(out<4>) AT=3.402000n
.MEASURE TRAN m_out5_x19 FIND V(out<5>) AT=3.402000n
.MEASURE TRAN m_out6_x19 FIND V(out<6>) AT=3.402000n
.MEASURE TRAN m_out7_x19 FIND V(out<7>) AT=3.402000n
.MEASURE TRAN m_out8_x19 FIND V(out<8>) AT=3.402000n
.MEASURE TRAN m_out9_x19 FIND V(out<9>) AT=3.402000n
.MEASURE TRAN m_out10_x19 FIND V(out<10>) AT=3.402000n
.MEASURE TRAN m_out0_x20 FIND V(out<0>) AT=3.570000n
.MEASURE TRAN m_out1_x20 FIND V(out<1>) AT=3.570000n
.MEASURE TRAN m_out2_x20 FIND V(out<2>) AT=3.570000n
.MEASURE TRAN m_out3_x20 FIND V(out<3>) AT=3.570000n
.MEASURE TRAN m_out4_x20 FIND V(out<4>) AT=3.570000n
.MEASURE TRAN m_out5_x20 FIND V(out<5>) AT=3.570000n
.MEASURE TRAN m_out6_x20 FIND V(out<6>) AT=3.570000n
.MEASURE TRAN m_out7_x20 FIND V(out<7>) AT=3.570000n
.MEASURE TRAN m_out8_x20 FIND V(out<8>) AT=3.570000n
.MEASURE TRAN m_out9_x20 FIND V(out<9>) AT=3.570000n
.MEASURE TRAN m_out10_x20 FIND V(out<10>) AT=3.570000n
.MEASURE TRAN m_out0_x21 FIND V(out<0>) AT=3.738000n
.MEASURE TRAN m_out1_x21 FIND V(out<1>) AT=3.738000n
.MEASURE TRAN m_out2_x21 FIND V(out<2>) AT=3.738000n
.MEASURE TRAN m_out3_x21 FIND V(out<3>) AT=3.738000n
.MEASURE TRAN m_out4_x21 FIND V(out<4>) AT=3.738000n
.MEASURE TRAN m_out5_x21 FIND V(out<5>) AT=3.738000n
.MEASURE TRAN m_out6_x21 FIND V(out<6>) AT=3.738000n
.MEASURE TRAN m_out7_x21 FIND V(out<7>) AT=3.738000n
.MEASURE TRAN m_out8_x21 FIND V(out<8>) AT=3.738000n
.MEASURE TRAN m_out9_x21 FIND V(out<9>) AT=3.738000n
.MEASURE TRAN m_out10_x21 FIND V(out<10>) AT=3.738000n
.MEASURE TRAN m_out0_x22 FIND V(out<0>) AT=3.906000n
.MEASURE TRAN m_out1_x22 FIND V(out<1>) AT=3.906000n
.MEASURE TRAN m_out2_x22 FIND V(out<2>) AT=3.906000n
.MEASURE TRAN m_out3_x22 FIND V(out<3>) AT=3.906000n
.MEASURE TRAN m_out4_x22 FIND V(out<4>) AT=3.906000n
.MEASURE TRAN m_out5_x22 FIND V(out<5>) AT=3.906000n
.MEASURE TRAN m_out6_x22 FIND V(out<6>) AT=3.906000n
.MEASURE TRAN m_out7_x22 FIND V(out<7>) AT=3.906000n
.MEASURE TRAN m_out8_x22 FIND V(out<8>) AT=3.906000n
.MEASURE TRAN m_out9_x22 FIND V(out<9>) AT=3.906000n
.MEASURE TRAN m_out10_x22 FIND V(out<10>) AT=3.906000n
.MEASURE TRAN m_out0_x23 FIND V(out<0>) AT=4.074000n
.MEASURE TRAN m_out1_x23 FIND V(out<1>) AT=4.074000n
.MEASURE TRAN m_out2_x23 FIND V(out<2>) AT=4.074000n
.MEASURE TRAN m_out3_x23 FIND V(out<3>) AT=4.074000n
.MEASURE TRAN m_out4_x23 FIND V(out<4>) AT=4.074000n
.MEASURE TRAN m_out5_x23 FIND V(out<5>) AT=4.074000n
.MEASURE TRAN m_out6_x23 FIND V(out<6>) AT=4.074000n
.MEASURE TRAN m_out7_x23 FIND V(out<7>) AT=4.074000n
.MEASURE TRAN m_out8_x23 FIND V(out<8>) AT=4.074000n
.MEASURE TRAN m_out9_x23 FIND V(out<9>) AT=4.074000n
.MEASURE TRAN m_out10_x23 FIND V(out<10>) AT=4.074000n
.MEASURE TRAN m_out0_x24 FIND V(out<0>) AT=4.242000n
.MEASURE TRAN m_out1_x24 FIND V(out<1>) AT=4.242000n
.MEASURE TRAN m_out2_x24 FIND V(out<2>) AT=4.242000n
.MEASURE TRAN m_out3_x24 FIND V(out<3>) AT=4.242000n
.MEASURE TRAN m_out4_x24 FIND V(out<4>) AT=4.242000n
.MEASURE TRAN m_out5_x24 FIND V(out<5>) AT=4.242000n
.MEASURE TRAN m_out6_x24 FIND V(out<6>) AT=4.242000n
.MEASURE TRAN m_out7_x24 FIND V(out<7>) AT=4.242000n
.MEASURE TRAN m_out8_x24 FIND V(out<8>) AT=4.242000n
.MEASURE TRAN m_out9_x24 FIND V(out<9>) AT=4.242000n
.MEASURE TRAN m_out10_x24 FIND V(out<10>) AT=4.242000n
.MEASURE TRAN m_out0_x25 FIND V(out<0>) AT=4.410000n
.MEASURE TRAN m_out1_x25 FIND V(out<1>) AT=4.410000n
.MEASURE TRAN m_out2_x25 FIND V(out<2>) AT=4.410000n
.MEASURE TRAN m_out3_x25 FIND V(out<3>) AT=4.410000n
.MEASURE TRAN m_out4_x25 FIND V(out<4>) AT=4.410000n
.MEASURE TRAN m_out5_x25 FIND V(out<5>) AT=4.410000n
.MEASURE TRAN m_out6_x25 FIND V(out<6>) AT=4.410000n
.MEASURE TRAN m_out7_x25 FIND V(out<7>) AT=4.410000n
.MEASURE TRAN m_out8_x25 FIND V(out<8>) AT=4.410000n
.MEASURE TRAN m_out9_x25 FIND V(out<9>) AT=4.410000n
.MEASURE TRAN m_out10_x25 FIND V(out<10>) AT=4.410000n
.MEASURE TRAN m_out0_x26 FIND V(out<0>) AT=4.578000n
.MEASURE TRAN m_out1_x26 FIND V(out<1>) AT=4.578000n
.MEASURE TRAN m_out2_x26 FIND V(out<2>) AT=4.578000n
.MEASURE TRAN m_out3_x26 FIND V(out<3>) AT=4.578000n
.MEASURE TRAN m_out4_x26 FIND V(out<4>) AT=4.578000n
.MEASURE TRAN m_out5_x26 FIND V(out<5>) AT=4.578000n
.MEASURE TRAN m_out6_x26 FIND V(out<6>) AT=4.578000n
.MEASURE TRAN m_out7_x26 FIND V(out<7>) AT=4.578000n
.MEASURE TRAN m_out8_x26 FIND V(out<8>) AT=4.578000n
.MEASURE TRAN m_out9_x26 FIND V(out<9>) AT=4.578000n
.MEASURE TRAN m_out10_x26 FIND V(out<10>) AT=4.578000n
.MEASURE TRAN m_out0_x27 FIND V(out<0>) AT=4.746000n
.MEASURE TRAN m_out1_x27 FIND V(out<1>) AT=4.746000n
.MEASURE TRAN m_out2_x27 FIND V(out<2>) AT=4.746000n
.MEASURE TRAN m_out3_x27 FIND V(out<3>) AT=4.746000n
.MEASURE TRAN m_out4_x27 FIND V(out<4>) AT=4.746000n
.MEASURE TRAN m_out5_x27 FIND V(out<5>) AT=4.746000n
.MEASURE TRAN m_out6_x27 FIND V(out<6>) AT=4.746000n
.MEASURE TRAN m_out7_x27 FIND V(out<7>) AT=4.746000n
.MEASURE TRAN m_out8_x27 FIND V(out<8>) AT=4.746000n
.MEASURE TRAN m_out9_x27 FIND V(out<9>) AT=4.746000n
.MEASURE TRAN m_out10_x27 FIND V(out<10>) AT=4.746000n
.MEASURE TRAN m_out0_x28 FIND V(out<0>) AT=4.914000n
.MEASURE TRAN m_out1_x28 FIND V(out<1>) AT=4.914000n
.MEASURE TRAN m_out2_x28 FIND V(out<2>) AT=4.914000n
.MEASURE TRAN m_out3_x28 FIND V(out<3>) AT=4.914000n
.MEASURE TRAN m_out4_x28 FIND V(out<4>) AT=4.914000n
.MEASURE TRAN m_out5_x28 FIND V(out<5>) AT=4.914000n
.MEASURE TRAN m_out6_x28 FIND V(out<6>) AT=4.914000n
.MEASURE TRAN m_out7_x28 FIND V(out<7>) AT=4.914000n
.MEASURE TRAN m_out8_x28 FIND V(out<8>) AT=4.914000n
.MEASURE TRAN m_out9_x28 FIND V(out<9>) AT=4.914000n
.MEASURE TRAN m_out10_x28 FIND V(out<10>) AT=4.914000n
.MEASURE TRAN m_out0_x29 FIND V(out<0>) AT=5.082000n
.MEASURE TRAN m_out1_x29 FIND V(out<1>) AT=5.082000n
.MEASURE TRAN m_out2_x29 FIND V(out<2>) AT=5.082000n
.MEASURE TRAN m_out3_x29 FIND V(out<3>) AT=5.082000n
.MEASURE TRAN m_out4_x29 FIND V(out<4>) AT=5.082000n
.MEASURE TRAN m_out5_x29 FIND V(out<5>) AT=5.082000n
.MEASURE TRAN m_out6_x29 FIND V(out<6>) AT=5.082000n
.MEASURE TRAN m_out7_x29 FIND V(out<7>) AT=5.082000n
.MEASURE TRAN m_out8_x29 FIND V(out<8>) AT=5.082000n
.MEASURE TRAN m_out9_x29 FIND V(out<9>) AT=5.082000n
.MEASURE TRAN m_out10_x29 FIND V(out<10>) AT=5.082000n
.MEASURE TRAN m_out0_x30 FIND V(out<0>) AT=5.250000n
.MEASURE TRAN m_out1_x30 FIND V(out<1>) AT=5.250000n
.MEASURE TRAN m_out2_x30 FIND V(out<2>) AT=5.250000n
.MEASURE TRAN m_out3_x30 FIND V(out<3>) AT=5.250000n
.MEASURE TRAN m_out4_x30 FIND V(out<4>) AT=5.250000n
.MEASURE TRAN m_out5_x30 FIND V(out<5>) AT=5.250000n
.MEASURE TRAN m_out6_x30 FIND V(out<6>) AT=5.250000n
.MEASURE TRAN m_out7_x30 FIND V(out<7>) AT=5.250000n
.MEASURE TRAN m_out8_x30 FIND V(out<8>) AT=5.250000n
.MEASURE TRAN m_out9_x30 FIND V(out<9>) AT=5.250000n
.MEASURE TRAN m_out10_x30 FIND V(out<10>) AT=5.250000n
.MEASURE TRAN m_out0_x31 FIND V(out<0>) AT=5.418000n
.MEASURE TRAN m_out1_x31 FIND V(out<1>) AT=5.418000n
.MEASURE TRAN m_out2_x31 FIND V(out<2>) AT=5.418000n
.MEASURE TRAN m_out3_x31 FIND V(out<3>) AT=5.418000n
.MEASURE TRAN m_out4_x31 FIND V(out<4>) AT=5.418000n
.MEASURE TRAN m_out5_x31 FIND V(out<5>) AT=5.418000n
.MEASURE TRAN m_out6_x31 FIND V(out<6>) AT=5.418000n
.MEASURE TRAN m_out7_x31 FIND V(out<7>) AT=5.418000n
.MEASURE TRAN m_out8_x31 FIND V(out<8>) AT=5.418000n
.MEASURE TRAN m_out9_x31 FIND V(out<9>) AT=5.418000n
.MEASURE TRAN m_out10_x31 FIND V(out<10>) AT=5.418000n
.MEASURE TRAN m_out0_x32 FIND V(out<0>) AT=5.586000n
.MEASURE TRAN m_out1_x32 FIND V(out<1>) AT=5.586000n
.MEASURE TRAN m_out2_x32 FIND V(out<2>) AT=5.586000n
.MEASURE TRAN m_out3_x32 FIND V(out<3>) AT=5.586000n
.MEASURE TRAN m_out4_x32 FIND V(out<4>) AT=5.586000n
.MEASURE TRAN m_out5_x32 FIND V(out<5>) AT=5.586000n
.MEASURE TRAN m_out6_x32 FIND V(out<6>) AT=5.586000n
.MEASURE TRAN m_out7_x32 FIND V(out<7>) AT=5.586000n
.MEASURE TRAN m_out8_x32 FIND V(out<8>) AT=5.586000n
.MEASURE TRAN m_out9_x32 FIND V(out<9>) AT=5.586000n
.MEASURE TRAN m_out10_x32 FIND V(out<10>) AT=5.586000n

.END
