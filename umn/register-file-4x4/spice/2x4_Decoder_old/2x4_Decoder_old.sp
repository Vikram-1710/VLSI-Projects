** Generated for: hspiceD
** Generated on: Mar 10 13:50:36 2026
** Design library name: VD2_RF
** Design cell name: 2x4_Decoder
** Design view name: schematic

** Library name: VD2_RF
** Cell name: 2x4_Decoder
** View name: schematic
xmdut13 d0 b vdd vss nch_svt_mac l=16e-9 nfin=1 w=10e-9 multi=1 nf=1 sa=90e-9 sb=90e-9
xmdut12 d0 vss a vss nch_svt_mac l=16e-9 nfin=1 w=10e-9 multi=1 nf=2 sa=90e-9 sb=90e-9
xmdut11 d1 b a vss nch_svt_mac l=16e-9 nfin=1 w=10e-9 multi=1 nf=1 sa=90e-9 sb=90e-9
xmdut0 d1 vss vdd vss nch_svt_mac l=16e-9 nfin=1 w=10e-9 multi=1 nf=2 sa=90e-9 sb=90e-9
xmdut2 vss b vss vss nch_svt_mac l=16e-9 nfin=1 w=10e-9 multi=1 nf=2 sa=90e-9 sb=90e-9
xmdut6 d2 a b vss nch_svt_mac l=16e-9 nfin=1 w=10e-9 multi=1 nf=1 sa=90e-9 sb=90e-9
xmdut10 d3 a vss vss nch_svt_mac l=16e-9 nfin=1 w=10e-9 multi=1 nf=2 sa=90e-9 sb=90e-9
xmdut7 d3 a vdd vdd pch_svt_mac l=16e-9 nfin=1 w=10e-9 multi=1 nf=2 sa=90e-9 sb=90e-9
xmdut3 d2 a vdd vdd pch_svt_mac l=16e-9 nfin=1 w=10e-9 multi=1 nf=1 sa=90e-9 sb=90e-9
xmdut1 vss b vdd vdd pch_svt_mac l=16e-9 nfin=1 w=10e-9 multi=1 nf=2 sa=90e-9 sb=90e-9
.END
